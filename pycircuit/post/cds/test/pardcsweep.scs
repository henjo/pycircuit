parameters vdc1 = 1
parameters vdc2 = 1
parameters vdc3 = 1

// out = vdc1 - vdc2 + 2*vdc3
v1 (1 0) vsource dc=vdc1
v2 (2 1) vsource dc=-vdc2
v3 (out 2) vsource dc=2*vdc3

sweep1 sweep param=vdc3 start=10 stop=19 lin=3 {
    sweep2 sweep param=vdc2 start=1 stop=9 lin=3 {
	dc1 dc param=vdc1 start=1 stop=9 lin=3
	dc2 dc param=vdc1 start=100 stop=200 lin=3
    }
}
